* 05 - Difference (Subtractor) Amplifier Simulation
* Transfer Function: If R2/R1 = R4/R3: V_o = (R2/R1)*(V2 - V1)
* R1=10k, R2=20k (ratio 2.0); R3=10k, R4=20k (ratio 2.0)
.param Aol=1Meg GBW=100Meg
.lib opamp.sub

X1 inv noninv out opamp
R1 in1 inv 10k
R2 inv out 20k
R3 in2 noninv 10k
R4 noninv 0 20k

V1 in1 0 SINE(0 1.0 1k)
V2 in2 0 SINE(0 2.5 1k)

.tran 0 3m 0 1u
.meas tran Vdiff_in_pk MAX (V(in2)-V(in1)) FROM 1m TO 3m
.meas tran Vout_pk MAX V(out) FROM 1m TO 3m
.meas tran Diff_Gain PARAM Vout_pk/Vdiff_in_pk
.end
